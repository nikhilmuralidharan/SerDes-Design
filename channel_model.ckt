* Equivalent circuit model for passive.ckt
.SUBCKT passive po1 po2
Vsp1 po1 p1 0
Vsr1 p1 pr1 0
Rp1 pr1 0 50
Ru1 u1 0 50
Fr1 u1 0 Vsr1 -1
Fu1 u1 0 Vsp1 -1
Ry1 y1 0 1
Gy1 p1 0 y1 0 -0.02
Vsp2 po2 p2 0
Vsr2 p2 pr2 0
Rp2 pr2 0 50
Ru2 u2 0 50
Fr2 u2 0 Vsr2 -1
Fu2 u2 0 Vsp2 -1
Ry2 y2 0 1
Gy2 p2 0 y2 0 -0.02
Rx1 x1 0 1
Fxc1_2 x1 0 Vx2 1.53039693236973
Cx1 x1 xm1 4.40797246822943e-09
Vx1 xm1 0 0
Gx1_1 x1 0 u1 0 -0.0642976275062062
Rx2 x2 0 1
Fxc2_1 x2 0 Vx1 -1.25548279074399
Cx2 x2 xm2 4.40797246822943e-09
Vx2 xm2 0 0
Gx2_1 x2 0 u1 0 0.0807245648197094
Rx3 x3 0 1
Cx3 x3 0 2.46549213144316e-12
Gx3_1 x3 0 u1 0 -0.770124999499718
Rx4 x4 0 1
Cx4 x4 0 1.19630316850063e-11
Gx4_1 x4 0 u1 0 -2.94779021408557
Rx5 x5 0 1
Cx5 x5 0 1.85575920715142e-11
Gx5_1 x5 0 u1 0 -1.4524141798457
Rx6 x6 0 1
Cx6 x6 0 8.71015574933799e-11
Gx6_1 x6 0 u1 0 -0.723696981114645
Rx7 x7 0 1
Cx7 x7 0 5.76402178565825e-10
Gx7_1 x7 0 u1 0 -0.0836349342702864
Rx8 x8 0 1
Cx8 x8 0 1.32870599746427e-08
Gx8_1 x8 0 u1 0 -0.864526165946903
Rx9 x9 0 1
Fxc9_10 x9 0 Vx10 1.54678156030363
Cx9 x9 xm9 4.40797246822943e-09
Vx9 xm9 0 0
Gx9_2 x9 0 u2 0 -0.065585823705072
Rx10 x10 0 1
Fxc10_9 x10 0 Vx9 -1.24218380985898
Cx10 x10 xm10 4.40797246822943e-09
Vx10 xm10 0 0
Gx10_2 x10 0 u2 0 0.0814696483627059
Rx11 x11 0 1
Cx11 x11 0 2.46549213144316e-12
Gx11_2 x11 0 u2 0 -0.765912580420026
Rx12 x12 0 1
Cx12 x12 0 1.19630316850063e-11
Gx12_2 x12 0 u2 0 -2.93832687073229
Rx13 x13 0 1
Cx13 x13 0 1.85575920715142e-11
Gx13_2 x13 0 u2 0 -1.44688685081862
Rx14 x14 0 1
Cx14 x14 0 8.71015574933799e-11
Gx14_2 x14 0 u2 0 -0.764608619610032
Rx15 x15 0 1
Cx15 x15 0 5.76402178565825e-10
Gx15_2 x15 0 u2 0 -0.0883827749207593
Rx16 x16 0 1
Cx16 x16 0 1.32870599746427e-08
Gx16_2 x16 0 u2 0 -0.864801123114167
Gyc1_1 y1 0 x1 0 -1
Gyc1_2 y1 0 x2 0 -1
Gyc1_3 y1 0 x3 0 0.896659236839467
Gyc1_4 y1 0 x4 0 -0.251812466807149
Gyc1_5 y1 0 x5 0 -0.115945836405024
Gyc1_6 y1 0 x6 0 -1
Gyc1_7 y1 0 x7 0 1
Gyc1_8 y1 0 x8 0 0.967775912693238
Gyc1_9 y1 0 x9 0 0.950734258884738
Gyc1_10 y1 0 x10 0 0.762957335276466
Gyc1_11 y1 0 x11 0 1
Gyc1_12 y1 0 x12 0 -1
Gyc1_13 y1 0 x13 0 1
Gyc1_14 y1 0 x14 0 0.854590627541513
Gyc1_15 y1 0 x15 0 -0.683797627643553
Gyc1_16 y1 0 x16 0 -1
Gyc2_1 y2 0 x1 0 0.966449428270719
Gyc2_2 y2 0 x2 0 0.766318473157596
Gyc2_3 y2 0 x3 0 1
Gyc2_4 y2 0 x4 0 -1
Gyc2_5 y2 0 x5 0 1
Gyc2_6 y2 0 x6 0 0.902117968230733
Gyc2_7 y2 0 x7 0 -0.71904696856952
Gyc2_8 y2 0 x8 0 -1
Gyc2_9 y2 0 x9 0 -1
Gyc2_10 y2 0 x10 0 -1
Gyc2_11 y2 0 x11 0 0.845122485248478
Gyc2_12 y2 0 x12 0 -0.183907547579736
Gyc2_13 y2 0 x13 0 -0.200559333630651
Gyc2_14 y2 0 x14 0 -1
Gyc2_15 y2 0 x15 0 1
Gyc2_16 y2 0 x16 0 0.967610953310297
.ENDS
